* /opt/geda/bin/xorn netlist --symbol-library /opt/geda/share/gEDA/sym/misc --symbol-library /opt/geda/share/gEDA/sym/power --symbol-library /opt/geda/share/gEDA/sym/relay --symbol-library /opt/geda/share/gEDA/sym/opto --symbol-library /opt/geda/share/gEDA/sym/supervisor --symbol-library /opt/geda/share/gEDA/sym/pla --symbol-library /opt/geda/share/gEDA/sym/rf --symbol-library /opt/geda/share/gEDA/sym/tube --symbol-library /opt/geda/share/gEDA/sym/transistor --symbol-library /opt/geda/share/gEDA/sym/micro --symbol-library /opt/geda/share/gEDA/sym/memory --symbol-library /opt/geda/share/gEDA/sym/bus --symbol-library /opt/geda/share/gEDA/sym/xilinx --symbol-library /opt/geda/share/gEDA/sym/st --symbol-library /opt/geda/share/gEDA/sym/philips --symbol-library /opt/geda/share/gEDA/sym/national --symbol-library /opt/geda/share/gEDA/sym/minicircuits --symbol-library /opt/geda/share/gEDA/sym/maxim --symbol-library /opt/geda/share/gEDA/sym/linear --symbol-library /opt/geda/share/gEDA/sym/lattice --symbol-library /opt/geda/share/gEDA/sym/irf --symbol-library /opt/geda/share/gEDA/sym/idt --symbol-library /opt/geda/share/gEDA/sym/dec --symbol-library /opt/geda/share/gEDA/sym/apex --symbol-library /opt/geda/share/gEDA/sym/amphenol --symbol-library /opt/geda/share/gEDA/sym/altera --symbol-library /opt/geda/share/gEDA/sym/allegro --symbol-library /opt/geda/share/gEDA/sym/asicpads --symbol-library /opt/geda/share/gEDA/sym/asic --symbol-library /opt/geda/share/gEDA/sym/switcap --symbol-library /opt/geda/share/gEDA/sym/spice --symbol-library /opt/geda/share/gEDA/sym/cascade --symbol-library /opt/geda/share/gEDA/sym/ecl --symbol-library /opt/geda/share/gEDA/sym/4000 --symbol-library /opt/geda/share/gEDA/sym/74 --symbol-library /opt/geda/share/gEDA/sym/IEC417 --symbol-library /opt/geda/share/gEDA/sym/titleblock --symbol-library /opt/geda/share/gEDA/sym/switch --symbol-library /opt/geda/share/gEDA/sym/radio --symbol-library /opt/geda/share/gEDA/sym/io --symbol-library /opt/geda/share/gEDA/sym/net-power --symbol-library /opt/geda/share/gEDA/sym/diode --symbol-library /opt/geda/share/gEDA/sym/connector --symbol-library /opt/geda/share/gEDA/sym/analog --symbol-library /opt/geda/share/gEDA/sym/local -g guile -O add-to-load-path=/opt/geda/share/gEDA/scheme -O load=/opt/geda/share/gEDA/scheme/gnetlist.scm -O load=/opt/geda/share/gEDA/scheme/gnet-spice-sdb.scm -O load=/opt/geda/share/gEDA/scheme/gnetlist-post.scm -O guile-proc=spice-sdb -O use-spice-netnames -v -o saida.cir exemplo.sch
*********************************************************
* Spice file generated by gnetlist                      *
* spice-sdb version 4.28.2007 by SDB --                 *
* provides advanced spice netlisting capability.        *
* Documentation at http://www.brorson.com/gEDA/SPICE/   *
*********************************************************
*==============  Begin SPICE netlist of main design ============
.control
run
plot v(in) v(out)
.endc

.tran 10us 5ms
C1 0 out 1u
R1 in out 20k
R2 in out 10k
V1 in 0 sin (0 10 1k)
.end
